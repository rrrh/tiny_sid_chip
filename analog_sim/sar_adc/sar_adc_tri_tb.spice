* SAR ADC Triangle Wave Testbench
* IHP SG13G2 PDK — VDD=1.2V
* Triangle analog input at 220, 440, 880 Hz — behavioral ADC reconstruction
* Tests quantization fidelity of the ADC

.include ../shared/pdk_include.spice

.param vdd_val=1.2
.param pi=3.14159265358979

* ============================================================
* StrongARM Comparator Subcircuit
* ============================================================
.subckt strongarm_comp vinp vinn outp outn clk vdd vss
XMtail vtail clk vss vss sg13_lv_nmos w=4e-6 l=0.13e-6
XMn1 dn vinp vtail vss sg13_lv_nmos w=2e-6 l=0.5e-6
XMn2 dp vinn vtail vss sg13_lv_nmos w=2e-6 l=0.5e-6
Bclkb clkb 0 V = {vdd_val} - v(clk)
XMp_rst1 dp clkb vdd vdd sg13_lv_pmos w=2e-6 l=0.13e-6
XMp_rst2 dn clkb vdd vdd sg13_lv_pmos w=2e-6 l=0.13e-6
XMn_cc1 outp outn dn vss sg13_lv_nmos w=1e-6 l=0.13e-6
XMn_cc2 outn outp dp vss sg13_lv_nmos w=1e-6 l=0.13e-6
XMp_cc1 outp outn vdd vdd sg13_lv_pmos w=1e-6 l=0.13e-6
XMp_cc2 outn outp vdd vdd sg13_lv_pmos w=1e-6 l=0.13e-6
XMp_rst3 outp clkb vdd vdd sg13_lv_pmos w=2e-6 l=0.13e-6
XMp_rst4 outn clkb vdd vdd sg13_lv_pmos w=2e-6 l=0.13e-6
.ends strongarm_comp

* ============================================================
* Binary-Weighted Cap DAC (8-bit, ideal)
* ============================================================
.subckt cap_dac_8bit sw7 sw6 sw5 sw4 sw3 sw2 sw1 sw0 vtop vref vss
Bvsw7 nsw7 0 V = v(sw7) > 0.6 ? v(vref) : v(vss)
C7 vtop nsw7 256f ic=0
Bvsw6 nsw6 0 V = v(sw6) > 0.6 ? v(vref) : v(vss)
C6 vtop nsw6 128f ic=0
Bvsw5 nsw5 0 V = v(sw5) > 0.6 ? v(vref) : v(vss)
C5 vtop nsw5 64f ic=0
Bvsw4 nsw4 0 V = v(sw4) > 0.6 ? v(vref) : v(vss)
C4 vtop nsw4 32f ic=0
Bvsw3 nsw3 0 V = v(sw3) > 0.6 ? v(vref) : v(vss)
C3 vtop nsw3 16f ic=0
Bvsw2 nsw2 0 V = v(sw2) > 0.6 ? v(vref) : v(vss)
C2 vtop nsw2 8f ic=0
Bvsw1 nsw1 0 V = v(sw1) > 0.6 ? v(vref) : v(vss)
C1 vtop nsw1 4f ic=0
Bvsw0 nsw0 0 V = v(sw0) > 0.6 ? v(vref) : v(vss)
C0 vtop nsw0 2f ic=0
Cdummy vtop vss 2f ic=0
.ends cap_dac_8bit

* ============================================================
* Triangle wave analog inputs (simulating DAC-equivalent levels)
* Range: 0V to 1.2V triangle centered at 0.6V, amplitude ±0.47V
* (code 28-228 → 0.132V-1.073V equivalent)
* ============================================================
Btri220 tri_in220 0 V = 0.6 + 0.47*(2/{pi})*asin(sin(2*{pi}*220*time - {pi}/2))
Btri440 tri_in440 0 V = 0.6 + 0.47*(2/{pi})*asin(sin(2*{pi}*440*time - {pi}/2))
Btri880 tri_in880 0 V = 0.6 + 0.47*(2/{pi})*asin(sin(2*{pi}*880*time - {pi}/2))

* ============================================================
* Behavioral ADC: quantize → reconstruct
* ADC code = floor(Vin/VDD * 255 + 0.5), clamped 0-255
* Reconstruction = code/255 * VDD
* ============================================================
Badc220_code adc220_code 0 V = min(255, max(0, floor(v(tri_in220)/{vdd_val}*255 + 0.5)))
Badc220_rec  adc220_rec  0 V = v(adc220_code)/255*{vdd_val}

Badc440_code adc440_code 0 V = min(255, max(0, floor(v(tri_in440)/{vdd_val}*255 + 0.5)))
Badc440_rec  adc440_rec  0 V = v(adc440_code)/255*{vdd_val}

Badc880_code adc880_code 0 V = min(255, max(0, floor(v(tri_in880)/{vdd_val}*255 + 0.5)))
Badc880_rec  adc880_rec  0 V = v(adc880_code)/255*{vdd_val}

* ============================================================
* Testbench
* Note: StrongARM comparator not instantiated here — 100MHz clock
* over 25ms causes timestep convergence issues. Comparator is
* validated separately in sar_adc_tb.spice. This TB focuses on
* quantization fidelity of the full ADC pipeline.
* ============================================================
Vdd vdd 0 {vdd_val}

.control
  shell rm -f sar_adc_tri_220.dat sar_adc_tri_440.dat sar_adc_tri_880.dat

  echo "=== SAR ADC Triangle Wave Test ==="

  * Transient: 25ms captures ≥5 cycles of 220 Hz
  tran 5u 25m

  * Write waveform files: input, ADC code, reconstructed
  wrdata sar_adc_tri_220.dat v(tri_in220) v(adc220_code) v(adc220_rec)
  wrdata sar_adc_tri_440.dat v(tri_in440) v(adc440_code) v(adc440_rec)
  wrdata sar_adc_tri_880.dat v(tri_in880) v(adc880_code) v(adc880_rec)

  * Measure fidelity: quantization error (input - reconstruction)
  echo "--- Quantization Fidelity (15-25ms window) ---"

  meas tran in220_max  max v(tri_in220)  from=15m to=25m
  meas tran in220_min  min v(tri_in220)  from=15m to=25m
  meas tran rec220_max max v(adc220_rec) from=15m to=25m
  meas tran rec220_min min v(adc220_rec) from=15m to=25m
  let in220_pp  = in220_max - in220_min
  let rec220_pp = rec220_max - rec220_min
  let err220_pp = in220_pp - rec220_pp
  echo "  220 Hz: input pk-pk=$&in220_pp V, recon pk-pk=$&rec220_pp V, err=$&err220_pp V"

  meas tran in440_max  max v(tri_in440)  from=15m to=25m
  meas tran in440_min  min v(tri_in440)  from=15m to=25m
  meas tran rec440_max max v(adc440_rec) from=15m to=25m
  meas tran rec440_min min v(adc440_rec) from=15m to=25m
  let in440_pp  = in440_max - in440_min
  let rec440_pp = rec440_max - rec440_min
  let err440_pp = in440_pp - rec440_pp
  echo "  440 Hz: input pk-pk=$&in440_pp V, recon pk-pk=$&rec440_pp V, err=$&err440_pp V"

  meas tran in880_max  max v(tri_in880)  from=15m to=25m
  meas tran in880_min  min v(tri_in880)  from=15m to=25m
  meas tran rec880_max max v(adc880_rec) from=15m to=25m
  meas tran rec880_min min v(adc880_rec) from=15m to=25m
  let in880_pp  = in880_max - in880_min
  let rec880_pp = rec880_max - rec880_min
  let err880_pp = in880_pp - rec880_pp
  echo "  880 Hz: input pk-pk=$&in880_pp V, recon pk-pk=$&rec880_pp V, err=$&err880_pp V"

  echo "  (Expect pk-pk error < 1 LSB = ~4.7mV)"
  echo "=== SAR ADC Triangle Test Complete ==="

.endc

.end

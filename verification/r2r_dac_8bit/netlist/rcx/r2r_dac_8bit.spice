* NGSPICE file created from r2r_dac_8bit.ext - technology: ihp-sg13g2

.subckt r2r_dac_8bit d0 d1 d2 d3 d4 d5 d6 d7 vout vdd vss
X0 a_1899_4300# a_2651_1900# vss.t7 rhigh l=3.68u w=2u
X1 a_6196_4300# a_6948_1900# vss.t22 rhigh l=3.68u w=2u
X2 a_5229_1900# d5.t0 vdd.t8 vdd.t0 sg13_lv_pmos ad=2.4p pd=12.8u as=2.4p ps=12.8u w=6u l=0.13u
X3 a_3510_1900# d3.t0 vdd.t1 vdd.t0 sg13_lv_pmos ad=2.4p pd=12.8u as=2.4p ps=12.8u w=6u l=0.13u
X4 a_932_1900# d0.t0 vss.t16 vss.t15 sg13_lv_nmos ad=1.2p pd=6.8u as=1.2p ps=6.8u w=3u l=0.13u
X5 a_5237_4800# a_6096_4800# vss.t19 rhigh l=3.675u w=2u
X6 a_3518_4800# a_4377_4800# vss.t14 rhigh l=3.675u w=2u
X7 a_5337_4300# a_6088_1900# vss.t19 rhigh l=3.675u w=2u
X8 a_3618_4300# a_4369_1900# vss.t14 rhigh l=3.675u w=2u
X9 a_2651_1900# d2.t0 vdd.t3 vdd.t0 sg13_lv_pmos ad=2.4p pd=12.8u as=2.4p ps=12.8u w=6u l=0.13u
X10 a_4477_4300# a_5237_4800# vss.t13 rhigh l=3.68u w=2u
X11 a_2659_4800# a_3518_4800# vss.t4 rhigh l=3.675u w=2u
X12 a_2759_4300# a_3510_1900# vss.t4 rhigh l=3.675u w=2u
X13 a_932_1900# d0.t0 vdd.t6 vdd.t0 sg13_lv_pmos ad=2.4p pd=12.8u as=2.4p ps=12.8u w=6u l=0.13u
X14 a_4369_1900# d4.t0 vss.t18 vss.t17 sg13_lv_nmos ad=1.2p pd=6.8u as=1.2p ps=6.8u w=3u l=0.13u
X15 a_940_4800# a_1799_4800# vss.t12 rhigh l=3.675u w=2u
X16 a_1899_4300# a_2659_4800# vss.t7 rhigh l=3.68u w=2u
X17 vdd.t9 a_940_4800# vss.t23 rhigh l=3.68u w=2u
X18 a_6196_4300# vout.t0 vss.t22 rhigh l=3.68u w=2u
X19 a_1040_4300# a_1791_1900# vss.t12 rhigh l=3.675u w=2u
X20 a_180_4300# a_932_1900# vss.t23 rhigh l=3.68u w=2u
X21 a_1791_1900# d1.t0 vss.t3 vss.t2 sg13_lv_nmos ad=1.2p pd=6.8u as=1.2p ps=6.8u w=3u l=0.13u
X22 a_6088_1900# d6.t0 vss.t11 vss.t10 sg13_lv_nmos ad=1.2p pd=6.8u as=1.2p ps=6.8u w=3u l=0.13u
X23 a_5337_4300# a_6096_4800# vss.t19 rhigh l=3.675u w=2u
X24 a_6948_1900# d7.t0 vss.t9 vss.t8 sg13_lv_nmos ad=1.2p pd=6.8u as=1.2p ps=6.8u w=3u l=0.13u
X25 a_3618_4300# a_4377_4800# vss.t14 rhigh l=3.675u w=2u
X26 a_4369_1900# d4.t0 vdd.t7 vdd.t0 sg13_lv_pmos ad=2.4p pd=12.8u as=2.4p ps=12.8u w=6u l=0.13u
X27 a_5229_1900# d5.t0 vss.t21 vss.t20 sg13_lv_nmos ad=1.2p pd=6.8u as=1.2p ps=6.8u w=3u l=0.13u
X28 a_4377_4800# a_5237_4800# vss.t13 rhigh l=3.68u w=2u
X29 a_3510_1900# d3.t0 vss.t1 vss.t0 sg13_lv_nmos ad=1.2p pd=6.8u as=1.2p ps=6.8u w=3u l=0.13u
X30 a_2759_4300# a_3518_4800# vss.t4 rhigh l=3.675u w=2u
X31 a_4477_4300# a_5229_1900# vss.t13 rhigh l=3.68u w=2u
X32 a_1791_1900# d1.t0 vdd.t2 vdd.t0 sg13_lv_pmos ad=2.4p pd=12.8u as=2.4p ps=12.8u w=6u l=0.13u
X33 a_6088_1900# d6.t0 vdd.t5 vdd.t0 sg13_lv_pmos ad=2.4p pd=12.8u as=2.4p ps=12.8u w=6u l=0.13u
X34 a_6948_1900# d7.t0 vdd.t4 vdd.t0 sg13_lv_pmos ad=2.4p pd=12.8u as=2.4p ps=12.8u w=6u l=0.13u
X35 a_2651_1900# d2.t0 vss.t6 vss.t5 sg13_lv_nmos ad=1.2p pd=6.8u as=1.2p ps=6.8u w=3u l=0.13u
X36 a_180_4300# a_940_4800# vss.t23 rhigh l=3.68u w=2u
X37 a_1040_4300# a_1799_4800# vss.t12 rhigh l=3.675u w=2u
X38 a_1799_4800# a_2659_4800# vss.t7 rhigh l=3.68u w=2u
X39 a_6096_4800# vout.t1 vss.t22 rhigh l=3.68u w=2u
R0 vss.t22 vss.t8 43087.6
R1 vss.n18 vss.n17 12000
R2 vss.t19 vss.t22 1428.57
R3 vss.t14 vss.t13 1428.57
R4 vss.t12 vss.t7 1428.57
R5 vss.t4 vss.t14 1426.91
R6 vss.t13 vss.t19 1426.91
R7 vss.t7 vss.t4 1426.91
R8 vss.n17 vss.t12 1299
R9 vss.t20 vss.t17 942.294
R10 vss.t2 vss.t15 941.198
R11 vss.t5 vss.n5 878.745
R12 vss.n11 vss.t0 809.716
R13 vss.n12 vss.t10 700.146
R14 vss.n16 vss.t10 614.683
R15 vss.n6 vss.t0 505.113
R16 vss.n6 vss.t5 436.086
R17 vss.t8 vss.n16 327.611
R18 vss.n18 vss.t15 310.08
R19 vss.n12 vss.t20 241.053
R20 vss.t17 vss.n11 131.483
R21 vss.n17 vss.t23 127.907
R22 vss.n5 vss.t2 63.5505
R23 vss.n5 vss.n4 34.1178
R24 vss.n7 vss.n6 34.1178
R25 vss.n11 vss.n10 34.1178
R26 vss.n13 vss.n12 34.1178
R27 vss.n16 vss.n15 34.1178
R28 vss.n19 vss.n18 34.1178
R29 vss vss.n19 22.4403
R30 vss.n15 vss.t9 3.32616
R31 vss.n9 vss.n1 2.7505
R32 vss.n3 vss.n0 2.74706
R33 vss.n0 vss.t16 2.68863
R34 vss.n3 vss.t3 2.68678
R35 vss.n2 vss.t6 2.68678
R36 vss.n8 vss.t1 2.68678
R37 vss.n9 vss.t18 2.68678
R38 vss.n1 vss.t21 2.68678
R39 vss.n14 vss.t11 2.68678
R40 vss.n10 vss.n8 2.51675
R41 vss.n4 vss.n2 2.36894
R42 vss.n15 vss.n14 1.90487
R43 vss.n14 vss.n13 1.80863
R44 vss.n7 vss.n2 1.34456
R45 vss.n8 vss.n7 1.19675
R46 vss.n13 vss.n1 0.732688
R47 vss.n19 vss.n0 0.584875
R48 vss.n4 vss.n3 0.175813
R49 vss.n10 vss.n9 0.0245625
R50 d5 d5.t0 56.1366
R51 vdd.t0 vdd.n8 43.0078
R52 vdd.t0 vdd.n3 43.0078
R53 vdd.n9 vdd.t0 43.0078
R54 vdd.t0 vdd.n1 43.0078
R55 vdd.n11 vdd.t9 34.1074
R56 vdd.n11 vdd.n10 13.2848
R57 vdd.n1 vdd.t4 11.7552
R58 vdd.n10 vdd.t6 10.8576
R59 vdd.n0 vdd.t2 10.8576
R60 vdd.n2 vdd.t3 10.8576
R61 vdd.n6 vdd.t1 10.8576
R62 vdd.n7 vdd.t7 10.8576
R63 vdd.n5 vdd.t8 10.8576
R64 vdd.n4 vdd.t5 10.8576
R65 vdd.n2 vdd.n0 1.8089
R66 vdd.n5 vdd.n4 1.8067
R67 vdd.n7 vdd.n6 1.8067
R68 vdd.n10 vdd.n9 1.1709
R69 vdd.n3 vdd.n2 1.1291
R70 vdd.n8 vdd.n7 1.0895
R71 vdd.n4 vdd.n1 0.8277
R72 vdd.n8 vdd.n5 0.6363
R73 vdd.n6 vdd.n3 0.5945
R74 vdd.n9 vdd.n0 0.5527
R75 vdd vdd.n11 0.0626867
R76 d3 d3.t0 53.0588
R77 d0 d0.t0 48.4432
R78 d2 d2.t0 51.521
R79 d4 d4.t0 54.5966
R80 vout vout.n0 32.7953
R81 vout.n0 vout.t0 16.623
R82 vout.n0 vout.t1 15.0005
R83 d1 d1.t0 49.981
R84 d6 d6.t0 57.6744
R85 d7 d7.t0 59.2144
C0 d0 d5 0.03291f
C1 a_3618_4300# a_4477_4300# 0.01579f
C2 a_6196_4300# a_6260_4780# 0.05121f
C3 vdd a_3518_4800# 0.01825f
C4 vdd a_4377_4800# 0.01825f
C5 vdd a_3510_1900# 1.3762f
C6 a_3518_4800# a_2659_4800# 0.01869f
C7 d3 d5 0.02463f
C8 vdd a_244_5280# 0.1584f
C9 a_6260_4280# a_6260_4780# 0.14569f
C10 vdd a_1899_4300# 0.0168f
C11 vdd a_2823_5280# 0.06988f
C12 vdd a_5229_1900# 1.37607f
C13 a_4477_4300# a_4369_1900# 0.22396f
C14 a_2823_5280# a_2659_4800# 0.03332f
C15 a_5401_4780# a_6196_4300# 0.02036f
C16 a_4377_4800# a_5237_4800# 0.01866f
C17 a_5401_4780# a_5401_4280# 0.14548f
C18 vdd a_6260_5280# 0.0646f
C19 a_3618_4300# vdd 0.01535f
C20 d1 d4 0.02451f
C21 a_180_4300# a_244_4280# 0.05121f
C22 a_5237_4800# a_5229_1900# 0.01485f
C23 d0 d4 0.03292f
C24 vdd a_1104_4780# 0.06357f
C25 a_1899_4300# a_2759_4300# 0.01577f
C26 a_932_1900# a_1040_4300# 0.22396f
C27 a_244_5280# a_940_4800# 0.05121f
C28 a_5337_4300# a_5229_1900# 0.22396f
C29 a_244_4280# a_1040_4300# 0.02036f
C30 a_2823_4780# a_3518_4800# 0.0512f
C31 vdd a_4369_1900# 1.37906f
C32 d2 d5 0.02449f
C33 d3 d4 1.41845f
C34 d7 d5 0.03157f
C35 a_3618_4300# a_2759_4300# 0.01579f
C36 a_6088_1900# a_6196_4300# 0.22396f
C37 vdd a_4477_4300# 0.01535f
C38 a_2823_5280# a_2823_4780# 0.14548f
C39 a_6088_1900# a_5401_4280# 0.05466f
C40 vdd a_1791_1900# 1.37869f
C41 a_244_4780# a_244_4280# 0.14569f
C42 d3 a_3510_1900# 0.14391f
C43 a_1963_4780# a_1799_4800# 0.02036f
C44 a_6088_1900# a_6260_4280# 0.02234f
C45 a_3618_4300# a_2823_4780# 0.02036f
C46 d5 d6 1.98065f
C47 a_1104_4780# a_940_4800# 0.02036f
C48 a_4477_4300# a_5337_4300# 0.01577f
C49 vdd a_1963_5280# 0.07134f
C50 a_1963_5280# a_2659_4800# 0.05121f
C51 vdd a_2659_4800# 0.01825f
C52 vout a_6260_5280# 0.08392f
C53 a_6196_4300# a_5401_4280# 0.02036f
C54 d2 d4 0.02463f
C55 d7 d4 0.03143f
C56 a_1899_4300# a_1104_4280# 0.02036f
C57 d1 a_1791_1900# 0.14391f
C58 a_180_4300# a_1040_4300# 0.01577f
C59 a_3510_1900# a_2651_1900# 0.0233f
C60 a_6196_4300# a_6260_4280# 0.05121f
C61 vdd a_5237_4800# 0.02088f
C62 vdd a_6948_1900# 1.14833f
C63 a_6096_4800# a_6260_5280# 0.03333f
C64 a_3510_1900# a_2823_4280# 0.05466f
C65 vdd a_5337_4300# 0.01848f
C66 d4 d6 0.02465f
C67 vdd a_2759_4300# 0.01535f
C68 a_244_4780# a_180_4300# 0.05121f
C69 vdd a_940_4800# 0.03771f
C70 a_1963_4780# a_1963_4280# 0.14569f
C71 a_2759_4300# a_2659_4800# 0.23795f
C72 vdd d1 0.20004f
C73 a_1104_4780# a_1104_4280# 0.14548f
C74 a_244_4780# a_1040_4300# 0.02036f
C75 a_5337_4300# a_5237_4800# 0.23795f
C76 vdd a_2823_4780# 0.04842f
C77 a_1104_4780# a_1104_5280# 0.14548f
C78 a_3618_4300# a_2823_4280# 0.02036f
C79 vdd d0 0.19252f
C80 a_6260_4780# a_6260_5280# 0.14569f
C81 a_2823_4780# a_2659_4800# 0.02036f
C82 a_4541_5280# a_4541_4780# 0.14569f
C83 vdd d3 0.20004f
C84 a_1791_1900# a_1104_4280# 0.05466f
C85 a_2651_1900# a_1791_1900# 0.02327f
C86 vdd vout 0.2232f
C87 a_2759_4300# a_2823_4780# 0.0512f
C88 vdd a_6096_4800# 0.02131f
C89 a_1899_4300# a_1799_4800# 0.23795f
C90 d0 d1 0.58382f
C91 vdd a_1104_4280# 0.14892f
C92 vout a_6948_1900# 0.09618f
C93 vdd a_1104_5280# 0.08545f
C94 vdd a_5401_5280# 0.06694f
C95 a_4541_5280# a_4377_4800# 0.03333f
C96 vdd a_2651_1900# 1.37868f
C97 d3 d1 0.02462f
C98 a_4541_4780# a_4541_4280# 0.14569f
C99 a_6096_4800# a_5237_4800# 0.01869f
C100 d2 vdd 0.20004f
C101 vdd d7 0.26031f
C102 vdd a_2823_4280# 0.13306f
C103 d3 d0 0.03295f
C104 a_6088_1900# a_5229_1900# 0.0233f
C105 a_2651_1900# a_2659_4800# 0.01485f
C106 vdd a_6260_4780# 0.04447f
C107 a_5401_5280# a_5237_4800# 0.03332f
C108 a_1104_4780# a_1799_4800# 0.0512f
C109 a_932_1900# a_1791_1900# 0.0233f
C110 vdd d6 0.20004f
C111 a_6948_1900# d7 0.14391f
C112 a_1104_5280# a_940_4800# 0.03332f
C113 a_2759_4300# a_2651_1900# 0.22396f
C114 a_3682_4780# a_3682_5280# 0.14548f
C115 a_1791_1900# a_1799_4800# 0.01485f
C116 a_2759_4300# a_2823_4280# 0.0512f
C117 vdd a_5401_4780# 0.04569f
C118 a_1899_4300# a_1963_4280# 0.05121f
C119 a_5401_4280# a_5229_1900# 0.02233f
C120 a_1899_4300# a_1040_4300# 0.01579f
C121 d2 d1 0.85613f
C122 d7 d1 0.03136f
C123 a_3518_4800# a_3682_5280# 0.03332f
C124 vdd a_932_1900# 1.37791f
C125 d2 d0 0.03309f
C126 a_2823_4280# a_2823_4780# 0.14548f
C127 a_4377_4800# a_3682_5280# 0.0512f
C128 vdd a_244_4280# 0.1207f
C129 d0 d7 0.03982f
C130 vout a_6096_4800# 0.02299f
C131 a_4541_4280# a_5229_1900# 0.05467f
C132 a_1899_4300# a_1963_4780# 0.05121f
C133 a_244_4780# a_244_5280# 0.14569f
C134 a_5401_4780# a_5237_4800# 0.02036f
C135 a_1963_5280# a_1799_4800# 0.03333f
C136 d2 d3 1.13751f
C137 vdd a_1799_4800# 0.0257f
C138 d3 d7 0.03138f
C139 a_5401_4780# a_5337_4300# 0.0512f
C140 d1 d6 0.02445f
C141 a_3682_4780# a_3682_4280# 0.14548f
C142 d0 d6 0.0329f
C143 a_1799_4800# a_2659_4800# 0.01866f
C144 a_1104_4780# a_1040_4300# 0.0512f
C145 vdd a_6088_1900# 1.38284f
C146 a_5401_5280# a_6096_4800# 0.0512f
C147 d5 d4 1.69927f
C148 a_4541_5280# vdd 0.06996f
C149 a_932_1900# a_940_4800# 0.01485f
C150 d3 d6 0.0245f
C151 vout a_6260_4780# 0.08832f
C152 a_3510_1900# a_3682_4280# 0.02233f
C153 a_4369_1900# a_4541_4280# 0.02234f
C154 a_1963_4280# a_1791_1900# 0.02234f
C155 a_6088_1900# a_6948_1900# 0.02327f
C156 a_932_1900# d0 0.14391f
C157 a_4477_4300# a_4541_4280# 0.05121f
C158 a_6260_4780# a_6096_4800# 0.02036f
C159 a_940_4800# a_1799_4800# 0.01869f
C160 a_4541_5280# a_5237_4800# 0.05121f
C161 d2 a_2651_1900# 0.14391f
C162 a_2651_1900# a_2823_4280# 0.02233f
C163 a_4541_4780# a_4377_4800# 0.02036f
C164 d5 a_5229_1900# 0.14391f
C165 d2 d7 0.03135f
C166 a_3618_4300# a_3682_4280# 0.0512f
C167 vdd a_180_4300# 0.03501f
C168 a_5401_4780# vout 0.01158f
C169 vdd a_6196_4300# 0.01873f
C170 vdd a_5401_4280# 0.11396f
C171 vdd a_1963_4280# 0.1171f
C172 vdd a_1040_4300# 0.02147f
C173 a_5401_4780# a_6096_4800# 0.0512f
C174 vdd a_6260_4280# 0.1307f
C175 vdd a_4541_4280# 0.13321f
C176 d2 d6 0.02445f
C177 a_3682_4780# a_3518_4800# 0.02036f
C178 d7 d6 2.2684f
C179 a_1963_4780# a_1963_5280# 0.14569f
C180 a_3682_4780# a_4377_4800# 0.0512f
C181 a_3682_4280# a_4369_1900# 0.05466f
C182 vdd a_1963_4780# 0.04944f
C183 vdd a_3682_5280# 0.06957f
C184 a_6196_4300# a_5337_4300# 0.01579f
C185 a_5401_4280# a_5337_4300# 0.0512f
C186 a_5401_4780# a_5401_5280# 0.14548f
C187 vdd a_244_4780# 0.08789f
C188 a_932_1900# a_1104_4280# 0.02233f
C189 a_1963_4780# a_2659_4800# 0.05121f
C190 a_3682_4280# a_4477_4300# 0.02036f
C191 a_6260_4280# a_6948_1900# 0.05467f
C192 a_4377_4800# a_3518_4800# 0.01869f
C193 a_3510_1900# a_3518_4800# 0.01485f
C194 a_2759_4300# a_1963_4280# 0.02036f
C195 a_5337_4300# a_4541_4280# 0.02036f
C196 a_3618_4300# a_3682_4780# 0.0512f
C197 a_2823_5280# a_3518_4800# 0.0512f
C198 a_940_4800# a_1040_4300# 0.23795f
C199 a_1104_5280# a_1799_4800# 0.0512f
C200 a_6088_1900# a_6096_4800# 0.01485f
C201 a_4477_4300# a_4541_4780# 0.05121f
C202 a_1963_4780# a_2759_4300# 0.02036f
C203 a_3618_4300# a_3518_4800# 0.23795f
C204 vdd a_3682_4280# 0.11519f
C205 a_3618_4300# a_3510_1900# 0.22396f
C206 a_244_4780# a_940_4800# 0.05121f
C207 vdd d5 0.20004f
C208 a_6088_1900# d7 0.01219f
C209 a_4369_1900# d4 0.14391f
C210 vout a_5401_4280# 0.01158f
C211 a_3682_4780# a_4477_4300# 0.02036f
C212 vdd a_4541_4780# 0.04847f
C213 a_1899_4300# a_1104_4780# 0.02036f
C214 a_4369_1900# a_4377_4800# 0.01485f
C215 a_6196_4300# a_6096_4800# 0.23795f
C216 vout a_6260_4280# 0.03667f
C217 a_3510_1900# a_4369_1900# 0.0233f
C218 a_6088_1900# d6 0.14391f
C219 a_932_1900# a_244_4280# 0.05467f
C220 a_4477_4300# a_4377_4800# 0.23795f
C221 a_4369_1900# a_5229_1900# 0.02327f
C222 a_4541_4780# a_5237_4800# 0.05121f
C223 a_1104_4280# a_1040_4300# 0.0512f
C224 a_1899_4300# a_1791_1900# 0.22396f
C225 vdd a_3682_4780# 0.04762f
C226 a_2651_1900# a_1963_4280# 0.05467f
C227 a_4541_4780# a_5337_4300# 0.02036f
C228 d1 d5 0.02446f
C229 vdd d4 0.20004f
C230 d7 vss 4.27117f
C231 d6 vss 3.26996f
C232 d5 vss 1.92769f
C233 d4 vss 1.93395f
C234 d3 vss 1.94024f
C235 d2 vss 1.95587f
C236 d1 vss 2.0043f
C237 d0 vss 2.39813f
C238 vout vss 1.16854f
C239 vdd vss 4.65764f
C240 a_6948_1900# vss 1.17017f
C241 a_6260_4280# vss 0.83246f $ **FLOATING
C242 a_6088_1900# vss 0.80396f
C243 a_5401_4280# vss 0.84011f $ **FLOATING
C244 a_5229_1900# vss 0.81012f
C245 a_4541_4280# vss 0.829f $ **FLOATING
C246 a_4369_1900# vss 0.80697f
C247 a_3682_4280# vss 0.84011f $ **FLOATING
C248 a_3510_1900# vss 0.80998f
C249 a_2823_4280# vss 0.82781f $ **FLOATING
C250 a_2651_1900# vss 0.80731f
C251 a_1963_4280# vss 0.84131f $ **FLOATING
C252 a_1791_1900# vss 0.80987f
C253 a_1104_4280# vss 0.82781f $ **FLOATING
C254 a_932_1900# vss 0.8427f
C255 a_244_4280# vss 0.87492f $ **FLOATING
C256 a_6260_4780# vss 0.77909f $ **FLOATING
C257 a_6196_4300# vss 0.2352f
C258 a_5401_4780# vss 0.77453f $ **FLOATING
C259 a_5337_4300# vss 0.21652f
C260 a_4541_4780# vss 0.77563f $ **FLOATING
C261 a_4477_4300# vss 0.21652f
C262 a_3682_4780# vss 0.77453f $ **FLOATING
C263 a_3618_4300# vss 0.21652f
C264 a_2823_4780# vss 0.77453f $ **FLOATING
C265 a_2759_4300# vss 0.21652f
C266 a_1963_4780# vss 0.77563f $ **FLOATING
C267 a_1899_4300# vss 0.21652f
C268 a_1104_4780# vss 0.77453f $ **FLOATING
C269 a_1040_4300# vss 0.21652f
C270 a_244_4780# vss 0.77909f $ **FLOATING
C271 a_180_4300# vss 0.45656f
C272 a_6260_5280# vss 0.88641f $ **FLOATING
C273 a_6096_4800# vss 0.34255f
C274 a_5401_5280# vss 0.8817f $ **FLOATING
C275 a_5237_4800# vss 0.34255f
C276 a_4541_5280# vss 0.88295f $ **FLOATING
C277 a_4377_4800# vss 0.34255f
C278 a_3682_5280# vss 0.8817f $ **FLOATING
C279 a_3518_4800# vss 0.34255f
C280 a_2823_5280# vss 0.8817f $ **FLOATING
C281 a_2659_4800# vss 0.34255f
C282 a_1963_5280# vss 0.88295f $ **FLOATING
C283 a_1799_4800# vss 0.34255f
C284 a_1104_5280# vss 0.8817f $ **FLOATING
C285 a_940_4800# vss 0.36122f
C286 a_244_5280# vss 0.88641f $ **FLOATING
C287 d7.t0 vss 0.94409f
C288 d6.t0 vss 0.95904f
.ends

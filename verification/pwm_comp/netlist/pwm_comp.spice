* PWM Comparator — IHP SG13G2 simulation netlist
* OTA (5T, diode-connected tail) + CMOS inverter
* Total: 4 NMOS + 3 PMOS
*
* Uses X prefix for subcircuit-based PDK models (sg13_lv_nmos/pmos)

.subckt pwm_comp vinp vinn out vdd vss

* OTA: 5-transistor differential pair with current mirror load
* M5: Tail current source (diode-connected)
XM5  tail tail vss vss sg13_lv_nmos w=2.0e-6 l=0.5e-6
* M1, M2: NMOS differential pair
XM1  mirr vinp tail vss sg13_lv_nmos w=4.0e-6 l=0.5e-6
XM2  ota_o vinn tail vss sg13_lv_nmos w=4.0e-6 l=0.5e-6
* M3, M4: PMOS current mirror load (M3 diode-connected)
XM3  mirr mirr vdd vdd sg13_lv_pmos w=2.0e-6 l=0.5e-6
XM4  ota_o mirr vdd vdd sg13_lv_pmos w=2.0e-6 l=0.5e-6

* CMOS Inverter: sharpens OTA output to rail-to-rail
XM6  out ota_o vss vss sg13_lv_nmos w=0.5e-6 l=0.13e-6
XM7  out ota_o vdd vdd sg13_lv_pmos w=1.0e-6 l=0.13e-6

.ends pwm_comp

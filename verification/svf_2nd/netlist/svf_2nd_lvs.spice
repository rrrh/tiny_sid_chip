* 2nd-order Switched-Capacitor SVF — IHP SG13G2 LVS reference netlist
* Matches extracted layout topology exactly (48 MOSFETs + 9 MIM caps)

.subckt svf_2nd vss sel0 vout vdd q0 q1 q2 q3 sel1 vin sc_clk

* OTA diff pairs (L=0.5u W=4u NMOS)
M1  n79 n72 vin  vss  sg13_lv_nmos w=4.0e-6 l=0.5e-6
M2  n79 n69 n81  vss  sg13_lv_nmos w=4.0e-6 l=0.5e-6
M3  n78 vin n72  vss  sg13_lv_nmos w=4.0e-6 l=0.5e-6
M4  n78 n69 n80  vss  sg13_lv_nmos w=4.0e-6 l=0.5e-6

* OTA tails + bias (L=0.5u W=2u NMOS)
M5  vss n69 n78  vss  sg13_lv_nmos w=2.0e-6 l=0.5e-6
M10 vss n69 n69  vss  sg13_lv_nmos w=2.0e-6 l=0.5e-6
M12 vss n69 n79  vss  sg13_lv_nmos w=2.0e-6 l=0.5e-6

* OTA PMOS loads (L=0.5u W=2u PMOS)
M26 vdd n81 vin  vdd  sg13_lv_pmos w=2.0e-6 l=0.5e-6
M27 vdd n81 n81  vdd  sg13_lv_pmos w=2.0e-6 l=0.5e-6
M28 vdd n80 n72  vdd  sg13_lv_pmos w=2.0e-6 l=0.5e-6
M29 vdd n80 n80  vdd  sg13_lv_pmos w=2.0e-6 l=0.5e-6

* Bias diode PMOS (L=0.5u W=2u)
M34 vdd n69 n69  vdd  sg13_lv_pmos w=2.0e-6 l=0.5e-6

* NOL clock NMOS (L=0.13u W=1u)
M6  vss n76 n77   vss  sg13_lv_nmos w=1.0e-6 l=0.13e-6
M7  vss n75 n76   vss  sg13_lv_nmos w=1.0e-6 l=0.13e-6
M8  vss n74 n75   vss  sg13_lv_nmos w=1.0e-6 l=0.13e-6
M9  vss sc_clk n74 vss sg13_lv_nmos w=1.0e-6 l=0.13e-6

* NOL clock PMOS (L=0.13u W=2u)
M30 vdd n76 n77  vdd  sg13_lv_pmos w=2.0e-6 l=0.13e-6
M31 vdd n75 n76  vdd  sg13_lv_pmos w=2.0e-6 l=0.13e-6
M32 vdd n74 n75  vdd  sg13_lv_pmos w=2.0e-6 l=0.13e-6
M33 vdd sc_clk n74 vdd sg13_lv_pmos w=2.0e-6 l=0.13e-6

* Switches + mux NMOS (L=0.13u W=2u)
M11 n25 n49 n26  vss  sg13_lv_nmos w=2.0e-6 l=0.13e-6
M13 n5  sel0 vout vss sg13_lv_nmos w=2.0e-6 l=0.13e-6
M14 n19 n44 n20  vss  sg13_lv_nmos w=2.0e-6 l=0.13e-6
M15 n17 n42 n18  vss  sg13_lv_nmos w=2.0e-6 l=0.13e-6
M16 n23 n47 n24  vss  sg13_lv_nmos w=2.0e-6 l=0.13e-6
M17 q3  sel1 vout vss sg13_lv_nmos w=2.0e-6 l=0.13e-6
M18 n21 n46 n22  vss  sg13_lv_nmos w=2.0e-6 l=0.13e-6
M19 n29 q1  n30  vss  sg13_lv_nmos w=2.0e-6 l=0.13e-6
M20 n15 n37 n16  vss  sg13_lv_nmos w=2.0e-6 l=0.13e-6
M21 n33 q3  n34  vss  sg13_lv_nmos w=2.0e-6 l=0.13e-6
M22 n62 n63 vout vss  sg13_lv_nmos w=2.0e-6 l=0.13e-6
M23 n31 q2  n32  vss  sg13_lv_nmos w=2.0e-6 l=0.13e-6
M24 n27 q0  n28  vss  sg13_lv_nmos w=2.0e-6 l=0.13e-6
M25 vin n67 vout vss  sg13_lv_nmos w=2.0e-6 l=0.13e-6

* Switches + mux PMOS (L=0.13u W=4u)
M35 n23 n48 n24  vdd  sg13_lv_pmos w=4.0e-6 l=0.13e-6
M36 n21 n45 n22  vdd  sg13_lv_pmos w=4.0e-6 l=0.13e-6
M37 vin n68 vout vdd  sg13_lv_pmos w=4.0e-6 l=0.13e-6
M38 n19 n43 n20  vdd  sg13_lv_pmos w=4.0e-6 l=0.13e-6
M39 n17 n41 n18  vdd  sg13_lv_pmos w=4.0e-6 l=0.13e-6
M40 n29 n52 n30  vdd  sg13_lv_pmos w=4.0e-6 l=0.13e-6
M41 n15 n36 n16  vdd  sg13_lv_pmos w=4.0e-6 l=0.13e-6
M42 n5  n6  vout vdd  sg13_lv_pmos w=4.0e-6 l=0.13e-6
M43 n27 n51 n28  vdd  sg13_lv_pmos w=4.0e-6 l=0.13e-6
M44 q3  n59 vout vdd  sg13_lv_pmos w=4.0e-6 l=0.13e-6
M45 n33 n55 n34  vdd  sg13_lv_pmos w=4.0e-6 l=0.13e-6
M46 n62 n64 vout vdd  sg13_lv_pmos w=4.0e-6 l=0.13e-6
M47 n31 n53 n32  vdd  sg13_lv_pmos w=4.0e-6 l=0.13e-6
M48 n25 n50 n26  vdd  sg13_lv_pmos w=4.0e-6 l=0.13e-6

* Integration caps (18.3x18.3 MIM)
C49 n70 vss cap_cmim w=18.3e-6 l=18.3e-6
C50 n71 vss cap_cmim w=18.3e-6 l=18.3e-6

* CQ bit1 (4.75x9.5)
C51 n56 vss cap_cmim w=4.75e-6 l=9.5e-6

* 4.75x4.75 caps (CQ bit0 + switching caps)
C52 n11 vss cap_cmim w=4.75e-6 l=4.75e-6

* CQ bit2 (9.5x9.5)
C53 n57 vss cap_cmim w=9.5e-6 l=9.5e-6

* CQ bit3 (13.4x13.4)
C54 n65 vss cap_cmim w=13.4e-6 l=13.4e-6

* 4.75x4.75 caps (switching caps)
C55 n14 vss cap_cmim w=4.75e-6 l=4.75e-6
C56 n13 vss cap_cmim w=4.75e-6 l=4.75e-6

* CQ bit0 (4.75x4.75) - bottom plate floating (layout routing issue)
C57 n12 n2  cap_cmim w=4.75e-6 l=4.75e-6

.ends svf_2nd

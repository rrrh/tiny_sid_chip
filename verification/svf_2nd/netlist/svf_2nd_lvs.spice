* 2nd-order gm-C SVF — IHP SG13G2 LVS reference netlist
* 4 OTAs (5T each) + 2 bias mirrors + 3 mux NMOS + 2 MIM caps
* Pin order: D G S B (standard SPICE)

.SUBCKT svf_2nd vss vout sel[0] sel[1] vin ibias_fc ibias_q vdd

* OTA-Q diff pair (W=4u L=0.5u) — tail dp_q biased by ibias_q
M1  vss   vss      dp_q   psub sg13_lv_nmos w=4u l=0.5u
M2  out2  vss      dp_q   psub sg13_lv_nmos w=4u l=0.5u

* OTA-FC2 diff pair (W=4u L=0.5u) — tail dp_fc2 biased by ibias_fc
M3  out2d vss      dp_fc2 psub sg13_lv_nmos w=4u l=0.5u
M18 vss   dg4b     dp_fc2 psub sg13_lv_nmos w=4u l=0.5u

* OTA-FC3 diff pair (W=4u L=0.5u) — tail dp_fc3 biased by ibias_fc
M4  vss   dg4      dp_fc3 psub sg13_lv_nmos w=4u l=0.5u
M5  out3  vss      dp_fc3 psub sg13_lv_nmos w=4u l=0.5u

* OTA-SUM diff pair (W=4u L=0.5u) — tail dp_sum biased by ibias_fc
M19 vss   vss      dp_sum psub sg13_lv_nmos w=4u l=0.5u
M20 out1  vin      dp_sum psub sg13_lv_nmos w=4u l=0.5u

* OTA tail current sources (W=2u L=0.5u)
M9  dp_fc3  ibias_fc vss  psub sg13_lv_nmos w=2u l=0.5u
M14 dp_sum  ibias_fc vss  psub sg13_lv_nmos w=2u l=0.5u
M16 dp_fc2  ibias_fc vss  psub sg13_lv_nmos w=2u l=0.5u
M17 dp_q    ibias_q  vss  psub sg13_lv_nmos w=2u l=0.5u

* PMOS loads (W=2u L=0.5u)
M21 vss   out2  vdd  nw1 sg13_lv_pmos w=2u l=0.5u
M22 out2  out2  vdd  nw1 sg13_lv_pmos w=2u l=0.5u
M23 out1  out1  vdd  nw4 sg13_lv_pmos w=2u l=0.5u
M24 vss   out1  vdd  nw4 sg13_lv_pmos w=2u l=0.5u
M25 out2d out2d vdd  nw2 sg13_lv_pmos w=2u l=0.5u
M26 vss   out2d vdd  nw2 sg13_lv_pmos w=2u l=0.5u
M27 out3  out3  vdd  nw3 sg13_lv_pmos w=2u l=0.5u
M28 vss   out3  vdd  nw3 sg13_lv_pmos w=2u l=0.5u

* FC bias mirror (W=2u L=1u)
M12 ibias_fc ibias_fc vss psub sg13_lv_nmos w=2u l=1u
M6  mir_fc   ibias_fc vss psub sg13_lv_nmos w=2u l=1u

* Q bias mirror (W=2u L=1u)
M15 ibias_q  ibias_q  vss psub sg13_lv_nmos w=2u l=1u
M13 mir_q    ibias_q  vss psub sg13_lv_nmos w=2u l=1u

* Analog mux NMOS pass gates
M7  vout  sel[1] vss psub sg13_lv_nmos w=4u l=0.13u
M10 vout  mux_g  vin psub sg13_lv_nmos w=2u l=0.13u
M11 vout  sel[0] vss psub sg13_lv_nmos w=2u l=0.13u

* Integration MIM caps
C29 vss vss cap_cmim w=25.8u l=25.8u m=2

.ENDS svf_2nd
